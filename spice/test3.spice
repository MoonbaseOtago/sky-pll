#

.lib /home/paul/.volare/sky130A/libs.tech/ngspice/sky130.lib.spice tt
#.include "cp2.spice"
.include "cp2_extracted.cir"
.include "pd3.spice"
.include "dl4.spice"

.subckt sky130_fd_sc_hs__nor4_1 A B C D VGND VNB VPB VPWR Y
X0 VGND A Y VNB sky130_fd_pr__nfet_01v8_lvt w=0.74 l=0.15
X1 Y B VGND VNB sky130_fd_pr__nfet_01v8_lvt w=0.74 l=0.15
X2 a_144_368# B a_228_368# VPB sky130_fd_pr__pfet_01v8 w=1.12 l=0.15
X3 VGND C Y VNB sky130_fd_pr__nfet_01v8_lvt w=0.74 l=0.15
X4 a_228_368# C a_342_368# VPB sky130_fd_pr__pfet_01v8 w=1.12 l=0.15
X5 a_342_368# D Y VPB sky130_fd_pr__pfet_01v8 w=1.12 l=0.15
X6 Y D VGND VNB sky130_fd_pr__nfet_01v8_lvt w=0.74 l=0.15
X7 VPWR A a_144_368# VPB sky130_fd_pr__pfet_01v8 w=1.12 l=0.15
.ends

.subckt sky130_fd_sc_hs__mux2_1 A0 A1 S VGND VNB VPB VPWR X
X0 a_27_112# S VPWR VPB sky130_fd_pr__pfet_01v8 w=0.84 l=0.15
X1 a_304_74# A1 a_524_368# VPB sky130_fd_pr__pfet_01v8 w=1 l=0.15
X2 a_443_74# a_27_112# VGND VNB sky130_fd_pr__nfet_01v8_lvt w=0.74 l=0.15
X3 a_226_74# A1 a_304_74# VNB sky130_fd_pr__nfet_01v8_lvt w=0.74 l=0.15
X4 VPWR S a_223_368# VPB sky130_fd_pr__pfet_01v8 w=1 l=0.15
X5 VGND S a_226_74# VNB sky130_fd_pr__nfet_01v8_lvt w=0.74 l=0.15
X6 a_524_368# a_27_112# VPWR VPB sky130_fd_pr__pfet_01v8 w=1 l=0.15
X7 a_27_112# S VGND VNB sky130_fd_pr__nfet_01v8_lvt w=0.55 l=0.15
X8 VGND a_304_74# X VNB sky130_fd_pr__nfet_01v8_lvt w=0.74 l=0.15
X9 a_223_368# A0 a_304_74# VPB sky130_fd_pr__pfet_01v8 w=1 l=0.15
X10 a_304_74# A0 a_443_74# VNB sky130_fd_pr__nfet_01v8_lvt w=0.74 l=0.15
X11 VPWR a_304_74# X VPB sky130_fd_pr__pfet_01v8 w=1.12 l=0.15
.ends

.subckt sky130_fd_sc_hs__or2_1 A B VGND VNB VPB VPWR X
X0 a_63_368# B a_152_368# VPB sky130_fd_pr__pfet_01v8 w=0.84 l=0.15
X1 VGND B a_63_368# VNB sky130_fd_pr__nfet_01v8_lvt w=0.55 l=0.15
X2 a_152_368# A VPWR VPB sky130_fd_pr__pfet_01v8 w=0.84 l=0.15
X3 a_63_368# A VGND VNB sky130_fd_pr__nfet_01v8_lvt w=0.55 l=0.15
X4 VPWR a_63_368# X VPB sky130_fd_pr__pfet_01v8 w=1.12 l=0.15
X5 VGND a_63_368# X VNB sky130_fd_pr__nfet_01v8_lvt w=0.74 l=0.15
.ends

.subckt sky130_fd_sc_hs__dfxtp_1 CLK D VGND VNB VPB VPWR Q
X0 a_27_74# CLK VPWR VPB sky130_fd_pr__pfet_01v8 w=1.12 l=0.15
X1 a_454_503# a_206_368# a_561_463# VPB sky130_fd_pr__pfet_01v8 w=0.42 l=0.15
X2 a_1118_508# a_1210_314# VPWR VPB sky130_fd_pr__pfet_01v8 w=0.42 l=0.15
X3 VPWR a_561_463# a_713_458# VPB sky130_fd_pr__pfet_01v8 w=0.84 l=0.15
X4 a_1210_314# a_1011_424# VPWR VPB sky130_fd_pr__pfet_01v8 w=0.84 l=0.15
X5 VPWR a_1210_314# Q VPB sky130_fd_pr__pfet_01v8 w=1.12 l=0.15
X6 VGND a_1210_314# Q VNB sky130_fd_pr__nfet_01v8_lvt w=0.74 l=0.15
X7 a_561_463# a_27_74# a_668_503# VPB sky130_fd_pr__pfet_01v8 w=0.42 l=0.15
X8 a_1210_314# a_1011_424# VGND VNB sky130_fd_pr__nfet_01v8_lvt w=0.64 l=0.15
X9 a_561_463# a_206_368# a_731_101# VNB sky130_fd_pr__nfet_01v8_lvt w=0.42 l=0.15
X10 VGND D a_454_503# VNB sky130_fd_pr__nfet_01v8_lvt w=0.42 l=0.15
X11 a_1011_424# a_27_74# a_1168_124# VNB sky130_fd_pr__nfet_01v8_lvt w=0.42 l=0.15
X12 a_1011_424# a_206_368# a_1118_508# VPB sky130_fd_pr__pfet_01v8 w=0.42 l=0.15
X13 a_668_503# a_713_458# VPWR VPB sky130_fd_pr__pfet_01v8 w=0.42 l=0.15
X14 a_1168_124# a_1210_314# VGND VNB sky130_fd_pr__nfet_01v8_lvt w=0.42 l=0.15
X15 VPWR a_27_74# a_206_368# VPB sky130_fd_pr__pfet_01v8 w=1.12 l=0.15
X16 VGND a_27_74# a_206_368# VNB sky130_fd_pr__nfet_01v8_lvt w=0.74 l=0.15
X17 VGND a_561_463# a_713_458# VNB sky130_fd_pr__nfet_01v8_lvt w=0.55 l=0.15
X18 a_713_458# a_27_74# a_1011_424# VPB sky130_fd_pr__pfet_01v8 w=0.84 l=0.15
X19 a_731_101# a_713_458# VGND VNB sky130_fd_pr__nfet_01v8_lvt w=0.42 l=0.15
X20 a_713_458# a_206_368# a_1011_424# VNB sky130_fd_pr__nfet_01v8_lvt w=0.55 l=0.15
X21 VPWR D a_454_503# VPB sky130_fd_pr__pfet_01v8 w=0.42 l=0.15
X22 a_454_503# a_27_74# a_561_463# VNB sky130_fd_pr__nfet_01v8_lvt w=0.42 l=0.15
X23 a_27_74# CLK VGND VNB sky130_fd_pr__nfet_01v8_lvt w=0.74 l=0.15
.ends

.subckt sky130_fd_sc_hs__inv_1 A VGND VNB VPB VPWR Y
X0 VPWR A Y VPB sky130_fd_pr__pfet_01v8 w=1.12 l=0.15
X1 VGND A Y VNB sky130_fd_pr__nfet_01v8_lvt w=0.74 l=0.15
.ends

.subckt sky130_fd_sc_hs__xor2_1 A B VGND VNB VPB VPWR X
X0 a_355_368# a_194_125# X VPB sky130_fd_pr__pfet_01v8 w=1.12 l=0.15
X1 X a_194_125# VGND VNB sky130_fd_pr__nfet_01v8_lvt w=0.74 l=0.15
X2 VPWR A a_158_392# VPB sky130_fd_pr__pfet_01v8 w=1 l=0.15
X3 VGND A a_194_125# VNB sky130_fd_pr__nfet_01v8_lvt w=0.55 l=0.15
X4 a_194_125# B VGND VNB sky130_fd_pr__nfet_01v8_lvt w=0.55 l=0.15
X5 a_355_368# A VPWR VPB sky130_fd_pr__pfet_01v8 w=1.12 l=0.15
X6 a_455_87# B X VNB sky130_fd_pr__nfet_01v8_lvt w=0.74 l=0.15
X7 VPWR B a_355_368# VPB sky130_fd_pr__pfet_01v8 w=1.12 l=0.15
X8 VGND A a_455_87# VNB sky130_fd_pr__nfet_01v8_lvt w=0.74 l=0.15
X9 a_158_392# B a_194_125# VPB sky130_fd_pr__pfet_01v8 w=1 l=0.15
.ends

.subckt sky130_fd_sc_hs__nor2_1 A B VGND VNB VPB VPWR Y
X0 VPWR A a_116_368# VPB sky130_fd_pr__pfet_01v8 w=1.12 l=0.15
X1 VGND A Y VNB sky130_fd_pr__nfet_01v8_lvt w=0.74 l=0.15
X2 Y B VGND VNB sky130_fd_pr__nfet_01v8_lvt w=0.74 l=0.15
X3 a_116_368# B Y VPB sky130_fd_pr__pfet_01v8 w=1.12 l=0.15
.ends

.subckt sky130_fd_sc_hs__nor3_1 A B C VGND VNB VPB VPWR Y
X0 VGND C Y VNB sky130_fd_pr__nfet_01v8_lvt w=0.74 l=0.15
X1 Y B VGND VNB sky130_fd_pr__nfet_01v8_lvt w=0.74 l=0.15
X2 VPWR A a_114_368# VPB sky130_fd_pr__pfet_01v8 w=1.12 l=0.15
X3 a_114_368# B a_198_368# VPB sky130_fd_pr__pfet_01v8 w=1.12 l=0.15
X4 VGND A Y VNB sky130_fd_pr__nfet_01v8_lvt w=0.74 l=0.15
X5 a_198_368# C Y VPB sky130_fd_pr__pfet_01v8 w=1.12 l=0.15
.ends

.subckt sky130_fd_sc_hs__dfrbp_1 CLK D RESET_B VGND VNB VPB VPWR Q Q_N
X0 VGND RESET_B a_1624_74# VNB sky130_fd_pr__nfet_01v8_lvt w=0.42 l=0.15
X1 a_125_78# RESET_B VGND VNB sky130_fd_pr__nfet_01v8_lvt w=0.42 l=0.15
X2 VPWR a_1224_74# Q_N VPB sky130_fd_pr__pfet_01v8 w=1.12 l=0.15
X3 a_38_78# D a_125_78# VNB sky130_fd_pr__nfet_01v8_lvt w=0.42 l=0.15
X4 VGND a_319_360# a_498_360# VNB sky130_fd_pr__nfet_01v8_lvt w=0.74 l=0.15
X5 a_910_118# RESET_B VGND VNB sky130_fd_pr__nfet_01v8_lvt w=0.42 l=0.15
X6 VPWR a_319_360# a_498_360# VPB sky130_fd_pr__pfet_01v8 w=1.12 l=0.15
X7 VGND a_1224_74# Q_N VNB sky130_fd_pr__nfet_01v8_lvt w=0.74 l=0.15
X8 VPWR a_706_463# a_841_401# VPB sky130_fd_pr__pfet_01v8 w=1 l=0.15
X9 a_841_401# a_319_360# a_1224_74# VPB sky130_fd_pr__pfet_01v8 w=1 l=0.15
X10 a_1434_74# a_1482_48# VGND VNB sky130_fd_pr__nfet_01v8_lvt w=0.42 l=0.15
X11 a_1224_74# a_498_360# a_1465_471# VPB sky130_fd_pr__pfet_01v8 w=0.42 l=0.15
X12 VPWR a_2026_424# Q VPB sky130_fd_pr__pfet_01v8 w=1.12 l=0.15
X13 a_706_463# a_319_360# a_796_463# VPB sky130_fd_pr__pfet_01v8 w=0.42 l=0.15
X14 VPWR RESET_B a_706_463# VPB sky130_fd_pr__pfet_01v8 w=0.42 l=0.15
X15 a_1482_48# a_1224_74# VPWR VPB sky130_fd_pr__pfet_01v8 w=0.42 l=0.15
X16 a_38_78# RESET_B VPWR VPB sky130_fd_pr__pfet_01v8 w=0.42 l=0.15
X17 a_1465_471# a_1482_48# VPWR VPB sky130_fd_pr__pfet_01v8 w=0.42 l=0.15
X18 VGND a_2026_424# Q VNB sky130_fd_pr__nfet_01v8_lvt w=0.74 l=0.15
X19 a_319_360# CLK VGND VNB sky130_fd_pr__nfet_01v8_lvt w=0.74 l=0.15
X20 a_2026_424# a_1224_74# VPWR VPB sky130_fd_pr__pfet_01v8 w=0.84 l=0.15
X21 a_38_78# a_319_360# a_706_463# VNB sky130_fd_pr__nfet_01v8_lvt w=0.42 l=0.15
X22 a_796_463# a_841_401# VPWR VPB sky130_fd_pr__pfet_01v8 w=0.42 l=0.15
X23 VGND a_706_463# a_841_401# VNB sky130_fd_pr__nfet_01v8_lvt w=0.64 l=0.15
X24 a_319_360# CLK VPWR VPB sky130_fd_pr__pfet_01v8 w=1.12 l=0.15
X25 a_1224_74# a_319_360# a_1434_74# VNB sky130_fd_pr__nfet_01v8_lvt w=0.42 l=0.15
X26 a_2026_424# a_1224_74# VGND VNB sky130_fd_pr__nfet_01v8_lvt w=0.55 l=0.15
X27 a_706_463# a_498_360# a_832_118# VNB sky130_fd_pr__nfet_01v8_lvt w=0.42 l=0.15
X28 a_841_401# a_498_360# a_1224_74# VNB sky130_fd_pr__nfet_01v8_lvt w=0.64 l=0.15
X29 a_1624_74# a_1224_74# a_1482_48# VNB sky130_fd_pr__nfet_01v8_lvt w=0.42 l=0.15
X30 VPWR D a_38_78# VPB sky130_fd_pr__pfet_01v8 w=0.42 l=0.15
X31 a_38_78# a_498_360# a_706_463# VPB sky130_fd_pr__pfet_01v8 w=0.42 l=0.15
X32 VPWR RESET_B a_1482_48# VPB sky130_fd_pr__pfet_01v8 w=0.42 l=0.15
X33 a_832_118# a_841_401# a_910_118# VNB sky130_fd_pr__nfet_01v8_lvt w=0.42 l=0.15
.ends

.subckt sky130_fd_sc_hs__clkbuf_4 A VGND VNB VPB VPWR X
X0 VPWR a_83_270# X VPB sky130_fd_pr__pfet_01v8 w=1.12 l=0.15
X1 VPWR a_83_270# X VPB sky130_fd_pr__pfet_01v8 w=1.12 l=0.15
X2 VGND A a_83_270# VNB sky130_fd_pr__nfet_01v8_lvt w=0.42 l=0.15
X3 X a_83_270# VGND VNB sky130_fd_pr__nfet_01v8_lvt w=0.42 l=0.15
X4 VGND a_83_270# X VNB sky130_fd_pr__nfet_01v8_lvt w=0.42 l=0.15
X5 X a_83_270# VPWR VPB sky130_fd_pr__pfet_01v8 w=1.12 l=0.15
X6 X a_83_270# VPWR VPB sky130_fd_pr__pfet_01v8 w=1.12 l=0.15
X7 VGND a_83_270# X VNB sky130_fd_pr__nfet_01v8_lvt w=0.42 l=0.15
X8 X a_83_270# VGND VNB sky130_fd_pr__nfet_01v8_lvt w=0.42 l=0.15
X9 VPWR A a_83_270# VPB sky130_fd_pr__pfet_01v8 w=1.12 l=0.15
.ends

.SUBCKT sky130_fd_sc_hs__nand2_1 VPB VPWR VGND Y B A sky130_gnd
X1 VPWR B Y VPB sky130_fd_pr__pfet_01v8 L=0.15 W=1.12
X2 Y A VPWR VPB sky130_fd_pr__pfet_01v8 L=0.15 W=1.12
X3 VGND B \$8 sky130_gnd sky130_fd_pr__nfet_01v8_lvt L=0.15 W=0.74
X4 \$8 A Y sky130_gnd sky130_fd_pr__nfet_01v8_lvt L=0.15 W=0.74
.ENDS sky130_fd_sc_hs__nand2_1

.subckt sky130_fd_sc_hs__and2b_1 A_N B VGND VNB VPB VPWR X
X0 a_27_74# A_N VPWR VPB sky130_fd_pr__pfet_01v8 w=0.84 l=0.15
X1 a_266_98# B VPWR VPB sky130_fd_pr__pfet_01v8 w=0.84 l=0.15
X2 VGND a_266_98# X VNB sky130_fd_pr__nfet_01v8_lvt w=0.74 l=0.15
X3 a_353_98# B VGND VNB sky130_fd_pr__nfet_01v8_lvt w=0.64 l=0.15
X4 a_266_98# a_27_74# a_353_98# VNB sky130_fd_pr__nfet_01v8_lvt w=0.64 l=0.15
X5 VPWR a_27_74# a_266_98# VPB sky130_fd_pr__pfet_01v8 w=0.84 l=0.15
X6 VPWR a_266_98# X VPB sky130_fd_pr__pfet_01v8 w=1.12 l=0.15
X7 a_27_74# A_N VGND VNB sky130_fd_pr__nfet_01v8_lvt w=0.55 l=0.15
.ends

.SUBCKT sky130_fd_sc_hs__and2_1 VPB VPWR X B A VGND sky130_gnd
X1 VPWR A \$3 VPB sky130_fd_pr__pfet_01v8 L=0.15 W=0.84
X2 VPWR B \$3 VPB sky130_fd_pr__pfet_01v8 L=0.15 W=0.84
X3 VPWR \$3 X VPB sky130_fd_pr__pfet_01v8 L=0.15 W=1.12
X4 VGND B \$9 sky130_gnd sky130_fd_pr__nfet_01v8_lvt L=0.15 W=0.64
X5 VGND \$3 X sky130_gnd sky130_fd_pr__nfet_01v8_lvt L=0.15 W=0.74
X6 \$9 A \$3 sky130_gnd sky130_fd_pr__nfet_01v8_lvt L=0.15 W=0.64
.ENDS sky130_fd_sc_hs__and2_1

.subckt sky130_fd_sc_hs__and2b_2 A_N B VGND VNB VPB VPWR X
X0 a_27_74# A_N VPWR VPB sky130_fd_pr__pfet_01v8 w=0.84 l=0.15
X1 VGND a_198_48# X VNB sky130_fd_pr__nfet_01v8_lvt w=0.74 l=0.15
X2 VPWR B a_198_48# VPB sky130_fd_pr__pfet_01v8 w=1 l=0.15
X3 X a_198_48# VPWR VPB sky130_fd_pr__pfet_01v8 w=1.12 l=0.15
X4 X a_198_48# VGND VNB sky130_fd_pr__nfet_01v8_lvt w=0.74 l=0.15
X5 a_505_74# a_27_74# a_198_48# VNB sky130_fd_pr__nfet_01v8_lvt w=0.74 l=0.15
X6 a_198_48# a_27_74# VPWR VPB sky130_fd_pr__pfet_01v8 w=1 l=0.15
X7 VGND B a_505_74# VNB sky130_fd_pr__nfet_01v8_lvt w=0.74 l=0.15
X8 VPWR a_198_48# X VPB sky130_fd_pr__pfet_01v8 w=1.12 l=0.15
X9 a_27_74# A_N VGND VNB sky130_fd_pr__nfet_01v8_lvt w=0.55 l=0.15
.ends

* Instantiate the extracted subcircuit
XCP VGND BD UP_N VCTRL VC BU UP DOWN_N DOWN RESET VPWR VPWR VGND cp2

XPD  REFCLK LOCALCLK UP UP_N VPWR DOWN DOWN_N VGND pd3

XDL VCTRL VO_N_0 VO_N_1 VO_N_2 VO_N_3 VO_N_4 Y  VGND VPWR  BP BN line4

XBUF Y VGND VGND VPWR VPWR LOCALCLK sky130_fd_sc_hs__clkbuf_4

* Simulation sources
V0 VGND GND 0
V1 VPWR GND 1.8
#V2 LOCALCLK GND PULSE(0 1.8 1ns 100ps 100ps 10ns 20.1ns)
V3 REFCLK GND PULSE(  0 1.8 1ns 100ps 100ps 10ns 20ns)
#V4 VBIAS GND 0.6

* Simulation commands
.tran 0.05n 400000n
.control
save REFCLK LOCALCLK VCTRL UP DOWN VPWR UP_N DOWN_N BU BD
run
plot v(BD) v(VCTRL)
eprvcd -a REFCLK LOCALCLK VCTRL UP DOWN VPWR UP_N DOWN_N BU BD  >a.vcd
.endc
.end
